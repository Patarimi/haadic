# SP extraction bench
.include ./top.cir

Vgate gate 0 dc 1.8 ac 1 portnum 1 z0 50
Vdrain drain 0 dc 1.8 ac 1 portnum 2 Z0 50
Xdut gate drain 0 top

.control
sp lin 10 1G 10G
let d = -i(vdrain)
set filetype = ASCII
write {bench_path} y_1_1 y_2_1 y_1_2 y_2_2 d
.endc
