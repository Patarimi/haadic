* # DC extraction bench

Vgate gate 0 1.8
Vdrain drain 0 1.8
Xdut gate drain 0 top
.save i(vdrain) v(gate)
.lib '/mnt/c/Users/JoPo/.ciel/sky130A/libs.tech/combined/sky130.lib.spice' tt
.include /mnt/c/Users/JoPo/PycharmProjects/haadic/tmp/test_import0/top.cir

.control
dc Vgate 0 1.8 0.2
let d = -i(vdrain)
let g = v(gate)
set filetype = ASCII
write /mnt/c/Users/JoPo/PycharmProjects/haadic/tests/ref_files/flow/bench.raw d g
.endc
