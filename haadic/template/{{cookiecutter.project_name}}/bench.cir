# Circuit name

.control
write {bench} all
.endc
